* Thevenin - open circuit voltage
V1 L 0 5
R1 L J 200
R2 J A 400
R3 J 0 1000
.dc V1 4.999 5.001 0.001
.meas dc U_OC FIND V(A) AT=5
.end
